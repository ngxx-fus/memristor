//////////////////////////////////////////////////
// VerilogA model for memristor
// Modified version by Ngxx.Fus.
//////////////////////////////////////////////////

`include "disciplines.vams"
`include "constants.h"

// define meter units for w parameter
nature distance
  access = Metr;
  units = "m";
  abstol = 0.01n;
endnature

discipline Distance
  potential distance;
enddiscipline

module Memristor(p, n,w_position);
    inout p;//positive pin
    inout n;//negative pin
    output w_position;// w-width pin

    electrical p, n,gnd;
    Distance w_position;
    ground gnd;

    analog function integer sign;
        //Sign function for Constant edge cases
        real arg; input arg;
        sign = (arg >= 0 ? 1 : -1 );
    endfunction
    analog function integer stp;        //Stp function
        real arg; input arg;
        stp = (arg >= 0 ? 1 : 0 );
    endfunction

    parameter real model = 4;
    parameter real window_type=0;
    parameter real dt=1e-10;
    // user must specify dt same as max step size in
    // transient analysis & must be at least 3 orders
    //smaller than T period of the source
    parameter real init_state=0;
    // the initial state condition [0:1]
    //parameters definitions and default values
    parameter real Roff = 200000;
    parameter real Ron = 5000;
    parameter real D = 3e-9;
    parameter real uv = 1e-15;
    parameter real w_multiplied = 1e8;
    // transformation factor for w/X width
    // in meter units
    parameter real p_coeff = 2;
    // Windowing function coefficient
    parameter real J = 1;
    // for prodromakis Window function
    parameter real p_window_noise=1e-18;
    // provoke the w width not to get stuck at
    // 0 or D with p window
    parameter real threshhold_voltage=0;
    // local variables
    parameter real i_off = 115e-6;
    parameter real i_on = -8.9e-6;
    parameter real x_c = 107e-12;
    parameter real b = 500e-6;
    parameter real a_on = 2e-9;
    parameter real a_off = 1.2e-9;
    parameter real K_on=-10;
    parameter real K_off=5e-4;
    parameter real Alpha_on=3;
    parameter real Alpha_off=1;
    parameter real v_on=-0.3;
    parameter real v_off=0.02;
    parameter real IV_relation=0;
    // IV_relation=0 means linear V=IR.
    // IV_relation=1 means nonlinear V=I*exp{..}
    parameter real x_on=0;
    parameter real x_off=3e-09; // equals D
    // local variables
    // local variables
    real w;
    real dwdt;
    real w_last;
    real R;
    real sign_multply;
    real stp_multply;
    real first_iteration;
    real x;
    real dxdt;
    real x_last;
    real lambda;
///////////////////// MAIN /////////////////////
analog begin
    if(first_iteration==0) begin
        w_last=init_state*D;
        // if this is the first iteration,
        //start with w_init
        x_last=init_state*D;
        // if this is the first iteration,
        // start with x_init
    end
    ///////////////////// VTEAM model /////////////////////
    if (model==4) begin // VTEAM model
        if (V(p,n) >= v_off) begin
            dxdt =K_off*pow((V(p,n)/v_off-1),Alpha_off);
        end
        if (V(p,n) <= v_on) begin
            dxdt =K_on*pow((V(p,n)/v_on-1),Alpha_on);
        end
        if ((v_on<V(p,n)) && (V(p,n)<v_off)) begin
            dxdt=0;
        end
        // No window
        if (window_type==0) begin
            x=x_last+dt*dxdt;
        end // No window
        // Jogelkar window
        if (window_type==1) begin
                if (sign(V(p,n))==1) begin
                    sign_multply=0;
                    if(x<p_window_noise) begin
                        sign_multply=1;
                    end
                end
                if (sign(V(p,n))==-1) begin
                    sign_multply=0;
                    if(x>(D-p_window_noise)) begin
                        sign_multply=-1;
                    end
                end
                x=x_last+dt*dxdt*(1-pow(pow((2*x_last/D-1),2),p_coeff))+sign_multply*p_window_noise;
            end // Jogelkar window
        // Biolek window
        if (window_type==2) begin
            if (stp(-V(p,n))==1) begin
                stp_multply=1;
            end
            if (stp(-V(p,n))==0) begin
                stp_multply=0;
                end
            x=x_last+dt*dxdt*(1-pow(pow((x_last/D-stp_multply),2),p_coeff));
        end  // Biolek window
        // Prodromakis window
        if (window_type==3) begin
            if (sign(V(p,n))==1) begin
                sign_multply=0;
                if(x<p_window_noise) begin
                    sign_multply=1;
                end
            end
            if (sign(V(p,n))==-1) begin
                sign_multply=0;
                if(x>(D-p_window_noise)) begin
                    sign_multply=-1;
                end
            end
                    x=x_last+dt*dxdt*J*(1-pow((pow((x_last/D-0.5),2)+0.75),p_coeff))+sign_multply*p_window_noise;
        end  // Prodromakis window
        //Kvatinsky window2 VTEAM only
        if (window_type==5) begin
            if (V(p,n) >= 0) begin
                x=x_last+dt*dxdt*exp(-exp((x_last-a_off)/x_c));
            end
            if (V(p,n) < 0) begin
                x=x_last+dt*dxdt*exp(-exp((a_on-x_last)/x_c));
            end
        end // Kvatinsky window
        if (x>=D) begin
            dxdt=0;
            x=D;
        end
        if (x<=0) begin
            dxdt=0;
            x=0;
        end
        lambda = ln(Roff/Ron);
        //update the output ports(pins)
        x_last=x;
        Metr(w_position) <+ x/D;
        if (IV_relation==1) begin
            V(p,n) <+ Ron*I(p,n)*exp(lambda*(x-x_on)/(x_off-x_on));
        end
        else if (IV_relation==0) begin
            V(p,n) <+ (Roff*x/D+Ron*(1-x/D))*I(p,n);
        end
        first_iteration=1;
    end // end VTEAM model
end   // end analog
endmodule
